.title cell-sg13g2_a21o_1-pin-A1-cap
.include /home/marcus/.ciel/ciel/ihp-sg13g2/versions/ee974c3adc69d0f36adbf20577079f0df419d702/ihp-sg13g2/libs.ref/sg13g2_stdcell/spice/sg13g2_stdcell.spice
.include /home/marcus/.ciel/ciel/ihp-sg13g2/versions/ee974c3adc69d0f36adbf20577079f0df419d702/ihp-sg13g2/libs.tech/ngspice/models/sg13g2_moslv_mod.lib
.lib /home/marcus/.ciel/ciel/ihp-sg13g2/versions/ee974c3adc69d0f36adbf20577079f0df419d702/ihp-sg13g2/libs.tech/ngspice/models/cornerMOSlv.lib mos_tt
VDD VDD 0 1.2V
VSS VSS 0 0.0V
VNW VNW 0 1.2V
VPW VPW 0 0.0V
Iin 0 vin DC 0 AC 1uA
Rin 0 vin 10GOhm
CX vX 0 1pF
RX vX 0 10GOhm
CA2 vA2 0 1pF
RA2 vA2 0 10GOhm
CB1 vB1 0 1pF
RB1 vB1 0 10GOhm
Xdut vX vin vA2 vB1 VDD VSS sg13g2_a21o_1
.options TEMP = 25C
.options TNOM = 27C
.ac dec 100 10Hz 10GHz
.end
